; Maestro (ADE Assembler) session function family for the BAG skill server.
;
; ADE Assembler ("maestro") is the successor to ADE-XL and drives the same
; axl* SKILL API, so these entry points reuse the ADE-XL functions in
; bag_adexl_session.il with the "maestro" cellview instead of "adexl".  The
; maestro view (maestro.sdb + active.state) is authored in Virtuoso and
; opened in place; there is no separate instantiate step.
;
; As with ADE-XL, the simulation itself runs through the Ocean simulation
; interface (bag.interface.ocean.OceanInterface), not the skill server -- these
; functions only read and update the assembler setup database.
;
; Split out of start_bag_ICADV12d3.il like the other flavor families
; (cf. bag_adexl_session.il / bag_adel_session.il); shared helpers stay in the
; main file, which loads this file before starting the BAG server.

; Returns parameter and corner information of a maestro testbench.
;
; Unlike the ADE-XL get_testbench_info this NEVER writes to the setup
; database: the session opens read-only and closes without
; axlCommitSetupDB, because setupdb write operations on maestro views
; crash IC618 (SDB::setCurrentRunMode assertion, observed 2026-08-09).
; The open/close bracket is bag_with_adexl_session (bag_adexl_session.il),
; which also closes on error so a failed read never leaves the view open.
procedure( maestro_get_testbench_info(tb_lib tb_cell result_file "ttt")
    let( (session_name)
        session_name = "read_maestro"
        bag_with_adexl_session(tb_lib tb_cell "maestro" session_name "r"
            lambda( (session sdb)
                let( (test_names test_name ade_symbol asi_sess output_list corner_list en_list)
                    ; check that only one test is defined
                    test_names = cadr(axlGetTests(sdb))
                    when(length(test_names) != 1
                        error("Maestro testbench must have exactly 1 test defined.")
                    )

                    ; get output list
                    test_name = car(test_names)
                    ade_symbol = axlGetToolSession(session_name test_name)
                    asi_sess = sevEnvironment(ade_symbol)
                    output_list = setof(ele asiGetOutputList(asi_sess) ele->name)

                    ; get enabled corners
                    corner_list = cadr(axlGetCorners(sdb))
                    en_list = setof(corner corner_list axlGetEnabled(axlGetCorner(sdb corner)))

                    ; write testbench information to file
                    write_testbench_info_to_file(sdb result_file output_list en_list)

                    ; read-only: no commit; bag_with_adexl_session closes the
                    ; database and session
                    t
                )
            )
        )
    )
)

; Modify corners, parameters, and run options of a maestro testbench.
;
; Requires the display-attached session, like every other maestro
; operation here.  The setupdb crash that once ruled this path out
; (SDB::setCurrentRunMode assertion, 2026-08-09) was a headless-only
; failure: the same write sequence -- axlSetCurrentRunMode,
; axlSaveSetupState, axlMainAppSaveSetup, axlCommitSetupDB -- runs on
; maestro views in a GUI session, where adexl_start_simulation's run-mode
; defaulting has been exercising it since 2026-08-11.
procedure( maestro_modify_testbench(tb_lib tb_cell conf_file opt_file corner_file
                                    param_file env_params_file
                                    @optional (tb_view "maestro") (stim_file "") (corner_spec_file "") "ttttttt")
    modify_testbench(tb_lib tb_cell conf_file opt_file corner_file param_file
                     env_params_file tb_view stim_file corner_spec_file)
)
