; ADE-XL session function family for the BAG skill server.
;
; Split out of start_bag_ICADV12d3.il so each ADE flavor's testbench
; functions live in their own file (cf. bag_adel_session.il; a Maestro family will
; follow the same pattern). Shared helpers -- copy_testbench,
; create_config_view, edit_config_view, parse_data_from_file, ... --
; remain in start_bag_ICADV12d3.il, which loads this file before starting
; the BAG server.

; Write central corner definitions into an open setup database.
; spec rows are (name modelfile section enabled temperature), as BAG's
; read_corner_spec produces from the corner setup database.  ADE-XL's own
; axlLoadCorners accepts that file and imports nothing from it, and a corner
; whose model carries no section netlists "include <file>" with no section=
; at all, which spectre rejects (SFE-675).
;
; Only corners that already carry a model are rewritten.  axlPutModel does
; not create one -- every plausible form was tried on 2026-09-17 -- so a new
; corner has to come from the testbench's own ocnxlCorner call, which creates
; the corner and its model but cannot set the section.  The two halves meet
; here: the author script owns which corners exist, this owns what they mean.
procedure( bag_apply_corner_spec(sdb spec "gl")
    let( (cname mfile msect menable mtemp corner model report)
        report = ""
        foreach( entry spec
            cname = nth(0 entry) mfile = nth(1 entry) msect = nth(2 entry)
            menable = nth(3 entry) mtemp = nth(4 entry)
            corner = car(errset(axlGetCorner(sdb cname) t))
            model = and(corner car(errset(axlGetModel(corner "ocnModel0") t)))
            if( model then
                errset(axlSetModelFile(model mfile) t)
                errset(axlSetModelSection(model msect) t)
                when( nequal(mtemp "") errset(axlPutVar(corner "temperature" mtemp) t) )
                errset(axlSetEnabled(corner nequal(menable "0")) t)
                report = strcat(report sprintf(nil "%s=%s " cname msect))
            else
                report = strcat(report sprintf(nil "%s=absent " cname))
            )
        )
        report
    )
)

; Turn off the nominal point when a corner is enabled.
; ADE always carries a "_default" corner that simulates the test's own model
; libraries.  Once the enabled corner selects the same model section, the two
; points compute the same thing and every run pays for it twice.  The nominal
; point is only dropped when some other corner is actually enabled, so a setup
; with no enabled corner still has a point to run.
procedure( bag_disable_nominal_corner(sdb "g")
    let( (nominal live)
        live = setof(nm cadr(axlGetCorners(sdb))
                     nequal(nm "_default") && axlGetEnabled(axlGetCorner(sdb nm)))
        nominal = car(errset(axlGetCorner(sdb "_default") t))
        if( and(nominal live) then
            errset(axlSetEnabled(nominal nil) t)
            sprintf(nil "_default off, corners %L (now %L)" live
                    errset(axlGetEnabled(nominal) t))
        else
            sprintf(nil "_default kept, corners %L" live)
        )
    )
)

; opens an adexl session.  Returns a list of session name and setup database handle.
procedure( open_adexl_session(tb_lib tb_cell tb_view session_name mode "ttttt")
    let( (session sdb)
        unless( session = axlCreateSession(session_name)
            error("Cannot create temporary adexl session: %s" session_name)
        )
        unless( sdb = axlSetMainSetupDBLCV(session tb_lib tb_cell tb_view ?mode mode)
            axlCloseSession(session)
            error("Cannot load adexl database from %s__%s (%s)" tb_lib tb_cell tb_view)
        )
        list(session sdb)
    )
)

; Close an assembler setup database and its session.  Both calls are
; guarded so a handle the body already released is harmless.
procedure( bag_close_adexl_session(session sdb)
    when( sdb errset(axlCloseSetupDB(sdb) t) )
    when( session errset(axlCloseSession(session) t) )
    t
)

; Open the setup database of tb_lib/tb_cell/tb_view in the given mode, run
; body(session sdb) on it and close both whatever happens.
;
; Every setup edit used to open in "a" mode and close only on its last
; line, so an error anywhere in between (ADEXL-2404 inside a corner edit, an
; unsupported run mode, a view with several tests) left the view open for
; writing.  The next open of the same view then failed with ADEXL-9072 /
; "Cannot load adexl database" for the rest of the Virtuoso session
; (observed 2026-09-23 and again in the tutorial 5-8 student runs,
; 2026-10).  The error is re-raised after the close so the python caller
; still sees it; on the error path the database is closed without commit,
; discarding the partial edit.
procedure( bag_with_adexl_session(tb_lib tb_cell tb_view session_name mode body)
    let( (session_sdb session sdb result msg)
        session_sdb = open_adexl_session(tb_lib tb_cell tb_view session_name mode)
        session = car(session_sdb)
        sdb = cadr(session_sdb)
        result = errset(funcall(body session sdb) t)
        unless( result
            ; same message slot stdoutHandler (start_bag_ICADV12d3.il) relays
            ; to python; nil when the interpreter did not fill errset.errset
            msg = car(nthelem(5 errset.errset)) || "see CDS.log"
        )
        bag_close_adexl_session(session sdb)
        unless( result
            error("%s on %s__%s (%s) failed: %s" session_name tb_lib tb_cell tb_view msg)
        )
        car(result)
    )
)

; Enables only the given corners in the simulation setup database.
procedure( enable_adexl_corners( sdb corner_list env_param_list "gll")
    let( (env_name par_val_list corner)
        foreach(cur_name cadr(axlGetCorners(sdb))
            axlSetEnabled( axlGetCorner(sdb cur_name) member(cur_name corner_list) )
        )
        foreach(env_par_obj env_param_list
            env_name = car(env_par_obj)
            par_val_list = cadr(env_par_obj)
            corner = axlGetCorner(sdb env_name)
            foreach(par_val par_val_list
                axlPutVar(corner car(par_val) cadr(par_val))
            )
        )
    )
)

; Set testbench parameters
; val_list is an association list from variable names to variable values as string, which
; could be a constant value or a parametric sweep string
procedure( set_adexl_parameters(sdb par_val_list "gl")
    foreach( var_spec par_val_list
        axlPutVar(sdb car(var_spec) cadr(var_spec))
    )
)

; Writes BAG-injected stimulus/load lines to a per-testbench spectre file
; and returns its absolute path.  The path is stable on purpose (not a temp
; file): it ends up referenced from the saved ADE setup, and a vanished
; temp file would leave the state pointing at nothing.
procedure( bag_write_stimulus_file(tb_lib tb_cell stim_lines "ttl")
    let( (dir path p)
        sprintf(dir "%s/simulation" getWorkingDir())
        unless( isDir(dir)
            createDir(dir)
        )
        sprintf(dir "%s/bag_stimuli" dir)
        unless( isDir(dir)
            createDir(dir)
        )
        sprintf(path "%s/%s__%s.scs" dir tb_lib tb_cell)
        unless( p = outfile(path "w")
            error("bag_write_stimulus_file: cannot write %s" path)
        )
        fprintf(p "// BAG-injected stimuli/loads for %s__%s\n" tb_lib tb_cell)
        fprintf(p "simulator lang=spectre\n")
        foreach(line stim_lines
            fprintf(p "%s\n" line)
        )
        close(p)
        path
    )
)

; Applies a BAG stimulus spec to an ADE session's Simulation Files setup.
; stim_spec is nil (leave the setup untouched) or a list whose car is the
; mode: ("set" line1 line2 ...) writes the lines to the testbench's
; stimulus file and points 'stimulusFile at it; ("clear") empties that
; file.  The option value must be a list of paths (ADE-5007 rejects a
; bare string).
;
; "clear" rewrites the file instead of setting the option to nil: the
; nil write succeeds in-session, but the incremental axl setup save does
; not persist an option *removal* (verified on IC618, 2026-08-12), while
; ADE-L's full state rewrite does.  Emptying the file is the same write
; the "set" branch does, so it persists uniformly across flavors.
procedure( bag_apply_stimuli(session tb_lib tb_cell stim_spec "gttg")
    let( (lines)
        when( stim_spec
            lines = cond(
                ( car(stim_spec) == "clear" nil )
                ( car(stim_spec) == "set" cdr(stim_spec) )
                ( t error("bag_apply_stimuli: unknown stimulus mode %L"
                          car(stim_spec)) )
            )
            asiSetEnvOptionVal(session 'stimulusFile
                list(bag_write_stimulus_file(tb_lib tb_cell lines)))
        )
    )
)

; Write testbench information to file.
procedure( write_testbench_info_to_file(sdb result_file output_list en_corner_list)
    let( (p output_count)

        ; write testbench information to result_file
        p = outfile(result_file "w")

        fprintf(p "corners:\n")
        foreach( corn cadr(axlGetCorners(sdb))
            fprintf(p "  - %s\n" corn)
        )
        fprintf(p "enabled_corners:\n")
        foreach( corn en_corner_list
            fprintf(p "  - %s\n" corn)
        )
        fprintf(p "parameters:\n")
        if( var_list = cadr(axlGetVars(sdb)) then
            foreach( var_name var_list
                fprintf(p "  %s: \"%s\"\n" var_name axlGetVarValue(axlGetVar(sdb var_name)))
            )
        else
            fprintf(p "  {}\n")
        )
        fprintf(p "outputs:\n")
        output_count = 0
        foreach( out_obj output_list
            if( rexMatchp( "\"" out_obj->name) then
                warn("Output expression name (%s) have quotes, skipping" out_obj->name)
            else
                fprintf(p "  \"%s\": !!str %A\n" out_obj->name out_obj->expression)
                output_count = output_count + 1
            )
        )
        when( output_count == 0
            fprintf(p "  {}\n")
        )
        close(p)
    )
)

; Instantiates a testbench.
;
; Copy a testbench template to the desired location, replace instances, make config view,
; and also setup corner settings in adexl.
; this method will also record list of corners, global variables, and output expressions
; to result_file
procedure( instantiate_testbench(tb_cell targ_lib
                                 config_libs config_views config_stops
                                 default_corner corner_file def_files
                                 tech_lib result_file
                                 @optional (corner_spec_file "")
                                 "tttttttltt")
    let( (session_name tmp_state_name state_obj success)

        tmp_state_name = "orig_state"

        ; check if temporary ADE session state already exists, if so, delete it
        state_obj = ddGetObj(targ_lib tb_cell tmp_state_name)
        when( state_obj
            success = ddDeleteObj(state_obj)
            unless( success
                error("Cannot delete orig_state cellview.")
            )
        )

        ; create config view
        create_config_view(targ_lib tb_cell "config" config_libs config_views config_stops)

        ; session_name = "modify_adexl"
        session_name = sprintf(nil "modify_adexl_%d" bag_modify_adexl_counter)
        bag_modify_adexl_counter = bag_modify_adexl_counter + 1

        bag_with_adexl_session(targ_lib tb_cell "adexl" session_name "a"
            lambda( (session sdb)
                let( (test_names test_name test tool_args corner_list ade_symbol ade_session
                      output_list)
                    ; check that only one test is defined
                    test_names = cadr(axlGetTests(sdb))
                    when(length(test_names) != 1
                        error("ADEXL testbench must have exactly 1 test defined.")
                    )

                    ; save current test setup state
                    axlSaveSetupState(session "adexl_default" "All")

                    ; change all tests to use config view, and set all test's definition files
                    ; also get a list of defined output expressions
                    ; step 1: get ADE session
                    test_name = car(test_names)
                    ade_symbol = axlGetToolSession(session_name test_name)
                    ade_session = asiGetSession(ade_symbol)
                    ; step 2: save original ADE session
                    asiSaveState(ade_session ?name tmp_state_name ?option 'cellview ?lib targ_lib ?cell tb_cell)
                    ; step 3: change test library
                    test = axlGetTest(sdb test_name)
                    tool_args = axlGetTestToolArgs(test)
                    set_assoc_list(tool_args "view" "config")
                    set_assoc_list(tool_args "lib" targ_lib)
                    set_assoc_list(tool_args "cell" tb_cell)
                    axlSetTestToolArgs(test tool_args)
                    ; step 4: reopen ADE session, then load original ADE state
                    ade_symbol = axlGetToolSession(session_name test_name)
                    ade_session = asiGetSession(ade_symbol)
                    asiLoadState(ade_session ?name tmp_state_name ?option 'cellview)
                    asiSetEnvOptionVal(ade_session 'definitionFiles def_files)
                    output_list = setof(ele asiGetOutputList(ade_session) ele->name)
                    ; step 5: delete temporary ADE session state
                    state_obj = ddGetObj(targ_lib tb_cell tmp_state_name)
                    ddDeleteObj(state_obj)

                    axlMainAppSaveSetup(session_name)

                    ; load corner
                    unless(axlLoadCorners(sdb corner_file)
                        error("Error loading corner file %s to %s__%s (adexl)" corner_file targ_lib tb_cell)
                    )

                    ; central corner definitions, which axlLoadCorners does not import
                    when( nequal(corner_spec_file "")
                        printf("*Info* corner spec applied -> %L\n"
                               errset(bag_apply_corner_spec(sdb parse_data_from_file(corner_spec_file)) t))
                    )

                    ; set default corner
                    corner_list = list(default_corner)
                    enable_adexl_corners(sdb corner_list nil)

                    ; write testbench information to file
                    write_testbench_info_to_file(sdb result_file output_list corner_list)

                    ; save; bag_with_adexl_session closes the database and session
                    axlSaveSetupState(session "adexl_default" "All")
                    axlSaveSetupState(session "ocean_default" "All")
                    axlMainAppSaveSetup(session_name)
                    axlCommitSetupDB(sdb)
                )
            )
        )
    )
)

; Returns parameter and corner information of a testbench.
; tb_view selects the assembler cellview: "adexl" (default) or "maestro"
; (ADE Assembler shares the axl* API, cf. bag_maestro_session.il).
procedure( get_testbench_info(tb_lib tb_cell result_file @optional (tb_view "adexl"))
    let( (session_name)
        session_name = "read_adexl"
        bag_with_adexl_session(tb_lib tb_cell tb_view session_name "r"
            lambda( (session sdb)
                let( (test_names test_name ade_symbol asi_sess output_list corner_list en_list)
                    ; check that only one test is defined
                    test_names = cadr(axlGetTests(sdb))
                    when(length(test_names) != 1
                        error("ADEXL testbench must have exactly 1 test defined.")
                    )

                    ; get output list
                    test_name = car(test_names)
                    ade_symbol = axlGetToolSession(session_name test_name)
                    asi_sess = sevEnvironment(ade_symbol)
                    output_list = setof(ele asiGetOutputList(asi_sess) ele->name)

                    ; get enabled corners
                    corner_list = cadr(axlGetCorners(sdb))
                    en_list = setof(corner corner_list axlGetEnabled(axlGetCorner(sdb corner)))

                    ; write testbench information to file
                    write_testbench_info_to_file(sdb result_file output_list en_list)

                    ; bag_with_adexl_session closes the database and session
                    axlCommitSetupDB(sdb)
                )
            )
        )
    )
)

; Configure run options.  Used to setup monte carlo parameters.
; run_params is an association list of run options and their values.  The key "mode"
; corresponds to the run mode.
procedure( set_run_options(session sdb run_params "ggl")
    let( (run_mode opt_list run_opt)
        when( run_mode = cadr(assoc("mode" run_params))
                  ; no options for single run/sweep mode.
            cond( (run_mode == "Single Run, Sweeps and Corners"
                   opt_list = nil)
                  (run_mode == "Monte Carlo Sampling"
                   opt_list = '("mcnumpoints" "mcmethod") )
                  ('t
                      ; the caller's bag_with_adexl_session closes the
                      ; database and session
                      error("Unsupported run mode: %s" run_mode) )
            )
            foreach( opt_name opt_list
                when( opt_val = cadr(assoc(opt_name run_params))
                    run_opt = axlPutRunOption(sdb run_mode opt_name)
                    axlSetRunOptionValue(run_opt opt_val)
                )
            )
            axlSetCurrentRunMode(sdb run_mode)
        )
    )
)

; modify the given testbench.
; tb_lib and tb_cell describes the library and cell of the testbench to simulate.
; conf_file contains the config view settings.
; opt_file contains the association list of run mode options.
; corner_file contains a list of corners to simulate.
; param_file contains the association list of parameter values.
; tb_view selects the assembler cellview: "adexl" (default) or "maestro".
; stim_file, when non-empty, contains a BAG stimulus spec (see
; bag_apply_stimuli) applied to the view's single test.
procedure( modify_testbench(tb_lib tb_cell conf_file opt_file corner_file param_file env_params_file @optional (tb_view "adexl") (stim_file "") (corner_spec_file ""))
    let( (conf_list run_params corner_list param_values env_param_values session_name stim_spec)
        sprintf(session_name "bag_sim_adexl_%s" getCurrentTime())

        ; read inputs from file.
        conf_list = parse_data_from_file(conf_file)
        run_params = parse_data_from_file(opt_file)
        corner_list = parse_data_from_file(corner_file)
        param_values = parse_data_from_file(param_file)
        env_param_values = parse_data_from_file(env_params_file)
        stim_spec = if( nequal(stim_file "") parse_data_from_file(stim_file) nil )

        ; modify config view
        when( conf_list
            edit_config_view(tb_lib tb_cell "config" conf_list)
        )

        bag_with_adexl_session(tb_lib tb_cell tb_view session_name "a"
            lambda( (session sdb)
                let( (test_names)
                    ; central corner definitions first, so the enable step below
                    ; sees them; axlLoadCorners does not import them itself
                    when( nequal(corner_spec_file "")
                        printf("*Info* corner spec applied -> %L\n"
                               errset(bag_apply_corner_spec(sdb parse_data_from_file(corner_spec_file)) t))
                    )

                    ; change corners, parameters, and run options
                    enable_adexl_corners( sdb corner_list env_param_values)
                    printf("*Info* nominal point -> %L\n"
                           errset(bag_disable_nominal_corner(sdb) t))
                    set_adexl_parameters( sdb param_values )
                    set_run_options( session sdb run_params )

                    ; apply BAG stimuli to the test's ADE session (cf. the definition-file
                    ; write in instantiate_testbench, which uses the same tool-session path).
                    ; axlSaveSetup (the GUI save) pushes the tool-session change into the
                    ; ACTIVE test state; on maestro views the state saves below only
                    ; capture it in the named side states, and the run netlists from the
                    ; active state (verified on IC618, 2026-08-12 -- adexl views happen to
                    ; sync the active state through axlMainAppSaveSetup, maestro views do
                    ; not).
                    when( stim_spec
                        test_names = cadr(axlGetTests(sdb))
                        bag_apply_stimuli(asiGetSession(axlGetToolSession(session_name car(test_names)))
                                          tb_lib tb_cell stim_spec)
                        axlSaveSetup(session_name)
                    )

                    ; save; bag_with_adexl_session closes the database and session
                    axlSaveSetupState(session "adexl_default" "All")
                    axlSaveSetupState(session "ocean_default" "All")
                    axlMainAppSaveSetup(session_name)
                    axlCommitSetupDB(sdb)
                )
            )
        )
    )
)

; ---------------------------------------------------------------------------
; BAG-driven ADE-XL run submission (bypasses the ocean batch path, which
; needs a provisioned job policy this site does not have).
;
; axlRunSimulation executes asynchronously: the main session dispatches
; ICRP job virtuosos, evaluates the outputs when the jobs report back,
; and saves the run history into the view's results database
; (<lib>/<cell>/adexl/results/data/*.rdb, a SQLite file).  This
; procedure therefore only submits the run and returns immediately; the
; python caller (bag.interface.ade.AdexlSession) watches the rdb for
; completion and reads the evaluated outputs from it directly.  Blocking
; here would starve the very event processing that finishes the run --
; the same event-loop race adel_run_simulation suffers from.
;
; The setup database is opened in "a" mode on purpose: a read-only
; session executes the run but discards the history, leaving no rdb to
; read (observed on IC618, 2026-08-10).
;
; ocean-XL-authored setups (cf. laygo2 clkdiv_tb_adexl_author.ocn) leave
; the run mode unset (no <currentmode> in the setup database);
; axlRunSimulation then submits zero points and the ICRP job client
; idles empty-handed until the python-side timeout (observed on IC618,
; 2026-08-11; corners are enabled by default -- axlGetEnabled returns t
; even without an enabled= attribute -- so the run mode is the only
; missing piece).  When the run mode is empty, set the default
; single-run mode, persist it the way modify_testbench does, and reopen
; the setup so the run submission reads the committed state.  Setups
; that already carry a run mode (e.g. GUI-configured or maestro views)
; are left untouched.
procedure( adexl_start_simulation(tb_lib tb_cell @optional (tb_view "adexl"))
    let( (session_name session_sdb session sdb mode msg)
        sprintf(session_name "bag_axl_%s_%s" tb_lib tb_cell)
        ; a stale same-name session (e.g. from an interrupted earlier run)
        ; blocks axlCreateSession; drop it first.
        errset(axlCloseSession(session_name))
        session_sdb = open_adexl_session(tb_lib tb_cell tb_view session_name "a")
        session = car(session_sdb)
        sdb = cadr(session_sdb)
        mode = errset(axlGetCurrentRunMode(sdb))
        mode = when( mode car(mode) )
        when( null(mode) || mode == ""
            axlSetCurrentRunMode(sdb "Single Run, Sweeps and Corners")
            axlSaveSetupState(session "adexl_default" "All")
            axlMainAppSaveSetup(session_name)
            axlCommitSetupDB(sdb)
            axlCloseSetupDB(sdb)
            axlCloseSession(session)
            session_sdb = open_adexl_session(tb_lib tb_cell tb_view session_name "a")
            session = car(session_sdb)
            sdb = cadr(session_sdb)
        )
        ; a saved setup keeps "_default" enabled next to its corners, and
        ; corners without an enabled= attribute count as enabled, so the run
        ; would simulate the nominal point as well.  Drop it here too, not only
        ; in modify_testbench: runners that submit the saved setup as-is never
        ; go through modify_testbench.
        printf("*Info* nominal point -> %L\n"
               errset(bag_disable_nominal_corner(sdb) t))
        ; a submission failure must not leave the "a"-mode database open:
        ; the python caller only reaches adexl_close_simulation once this
        ; procedure has returned the session name.
        unless( errset(axlRunSimulation(?session session_name) t)
            msg = car(nthelem(5 errset.errset)) || "see CDS.log"
            bag_close_adexl_session(session sdb)
            error("adexl_start_simulation on %s__%s (%s) failed: %s" tb_lib tb_cell tb_view msg)
        )
        session_name
    )
)

; Closes the session opened by adexl_start_simulation, releasing the
; "a"-mode setup database so the view can be edited elsewhere.
procedure( adexl_close_simulation(session_name)
    errset(axlCloseSession(session_name) t)
    t
)
